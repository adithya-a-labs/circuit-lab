monostable_01 - original lab topology; National Semiconductor LM741 macromodel
.include /workspace/circuit-outputs/experiment-8-lm741/models/LM741_ngspice.lib
Vpos vp 0 15
Vneg vn 0 -15
.model D4148 D(Is=2.52n Rs=0.568 N=1.752 Cjo=4p M=0.4 Tt=20n)
R1 out plus 10k
R2 plus 0 10k
R out minus 15000
C minus 0 1e-07
D1 minus 0 D4148
Cd trigger diff 10n
Rd diff 0 470
D2 plus diff D4148
Vtrigger trigger 0 PULSE(0 -15 10m 50u 1u 0.1m 20m)
XU plus minus vp vn out LM741/NS
.options reltol=1e-5 abstol=1e-10 method=gear maxord=2
.control
set wr_singlescale
set wr_vecnames
tran 1e-06 0.07 0 1e-06
wrdata /workspace/circuit-outputs/experiment-8-lm741/simulation_data/monostable_01.txt v(out) v(trigger) v(minus) v(plus)
quit
.endc
.end
